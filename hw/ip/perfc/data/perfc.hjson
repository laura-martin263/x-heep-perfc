

{ name: "perfc"
  clock_primary: "clk_i"
  bus_interfaces: [
    { protocol: "reg_iface", direction: "device" }
  ]
  regwidth: "32"
  registers: [

    { name:     "CONTROL"
      desc:     "Registro de control. Si es 1, reset del contador."
      swaccess: "rw"
      hwaccess: "hrw"
      fields: [
        { bits: "31:0", name: "CONTROL", desc: "Registro de control. Si es 1, reset del contador." }
      ]
    }

    { name:     "TOTAL_CYCLES"
      desc:     "Total de ciclos activos"
      swaccess: "rw"
      hwaccess: "hrw"
      fields: [
        { bits: "31:0", name: "TOTAL_CYCLES", desc: "Total de ciclos activos." }
      ]
    }

    { name:     "CPU_ACTIVE_CYCLES"
      desc:     "Total de ciclos activos de la CPU"
      swaccess: "rw"
      hwaccess: "hrw"
      fields: [
        { bits: "31:0", name: "CPU_ACTIVE_CYCLES", desc: "Total de ciclos activos de la CPU." }
      ]
    }
  ]
}

